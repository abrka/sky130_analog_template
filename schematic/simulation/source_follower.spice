** sch_path: /home/abrka/projects/sky130_analog_template/schematic/source_follower.sch
.subckt source_follower VDD vin vout vbias GND
*.PININFO GND:I vin:I vbias:I VDD:I vout:O
XM1 VDD vin vout GND sky130_fd_pr__nfet_01v8 L=0.15 W=10 nf=1 m=1
XM2 vout vbias GND GND sky130_fd_pr__nfet_01v8 L=0.15 W=1 nf=1 m=1
**** begin user architecture code

** opencircuitdesign pdks install
.lib /home/abrka/.volare/sky130A/libs.tech/ngspice/sky130.lib.spice tt

**** end user architecture code
.ends
.end
